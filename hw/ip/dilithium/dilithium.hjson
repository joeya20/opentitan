{
  name:                 "dilithium",
  human_name:           "CRYSTALS-Dilithium Accelerator",
  one_line_desc:        "CRYSTALS-Dilithium KeyGen, Sign, and Validate engine",
  one_paragraph_desc:   '''

  '''
  clocking: [
    {clock: "clk", reset: "rst_n", primary: true}
  ],

  bus_interfaces: [
    { protocol: "tlul", direction: "device" }
  ],
  
  param_list: [
    # Regular parameters
    { name:    "BUS_W",
      type:    "int unsigned",
      default: "4",
      desc:    '''
      TODO
      '''
      local:   "false",
      expose:  "true"
    },
    { name:    "SAMPLE_W",
      type:    "int unsigned",
      default: "23",
      desc:    '''
      TODO
      '''
      local:   "false",
      expose:  "true"
    },
    { name:    "W",
      type:    "int unsigned",
      default: "64",
      desc:    '''
      Input and output data width
      '''
      local:   "false",
      expose:  "true"
    },
    # Note: All parameters below are local, they are not actually configurable.
    # Selecting values different from the default values below might cause undefined behavior.
    # NumRegsData controls the number of input/output data registers
    # this is a function of the W parameter
    { name:    "NumRegsData",
      type:    "int",
      default: "2",
      desc:    "Number registers for input and output data",
      local:   "true"
    }
  ],

  regwidth: "32", // standard register width
  register: [
  // input data registers
  { multireg: {
    name: "DATA_IN",
    resval: "0",
    desc: '''
    The input data must be written to these registers.
    '''
    count: "NumRegsData",
    cname: "DATA_IN",
    swaccess: "wo",
    hwaccess: "hrw",
    hwext:    "true",
    fields: [
      { bits: "31:0", name: "data_in", desc: "Input Data" }
    ]
    }
  },
  // output data registers
  { multireg: {
    name: "DATA_OUT",
    resval: "0",
    desc: '''
    The output data will be written to these registers.
    '''
    count: "NumRegsData",
    cname: "DATA_OUT",
    swaccess: "ro",
    hwaccess: "hrw",
    hwext:    "true",
    fields: [
      { bits: "31:0", name: "data_out", desc: "Output Data" }
    ]
    }
  },
  // CSRs
  {
    name: "CTRL",
    desc: '''
    Should only be updateable when idle.
    ''',
    swaccess: "rw",
    hwaccess: "hrw",
    hwext:    "true",
    fields: [
      {
        bits: "1:0",
        name: "OPERATION",
        resval: "0x0",
        desc: '''
        ''',
        enum: [
          { value: "0",
            name: "KEYGEN",
            desc: '''
            '''
          },
          { value: "1",
            name: "VERIFY",
            desc: '''
            '''
          },
          { value: "2",
            name: "SIGN",
            desc: '''
            '''
          },
        ]
      }
    ]
  },
  { name: "TRIGGER",
    desc: '''
      Trigger Register.
    '''
    swaccess: "wo",
    hwaccess: "hrw",
    fields: [
      { bits: "0",
        name: "START",
        resval: "0"
        desc:  '''
        '''
      }
    ]
  },
  { name: "STATUS",
    desc: "Status Register",
    swaccess: "ro",
    hwaccess: "hwo",
    fields: [
      { bits: "0",
        name: "IDLE",
        resval: "0",
        hwaccess: "hrw",
        desc:  '''
          The AES unit is idle (1) or busy (0).
          This flag is `0` if one of the following operations is currently running: i) encryption/decryption, ii) register clearing or iii) PRNG reseeding.
          This flag is also `0` if an encryption/decryption is running but the AES unit is stalled.
        '''
        tags: ["excl:CsrAllTests:CsrExclCheck"]
      }
      { bits: "1",
        name: "STALL",
        resval: "0"
        desc:  '''
          The AES unit is not stalled (0) or stalled (1) because there is previous
          output data that must be read by the processor before the AES unit can
          overwrite this data.
          This flag is not meaningful if MANUAL_OPERATION=1 (see Control Register).
        '''
        tags: ["excl:CsrNonInitTests:CsrExclCheck"]
      }
      { bits: "2",
        name: "OUTPUT_VALID",
        resval: "0"
        desc:  '''
          The AES unit has no valid output (0) or has valid output data (1).
        '''
        tags: ["excl:CsrNonInitTests:CsrExclCheck"]
      }
      { bits: "3",
        name: "INPUT_READY",
        resval: "0",
        desc:  '''
          The AES unit is ready (1) or not ready (0) to receive new data input via the DATA_IN registers.
          If the present values in the DATA_IN registers have not yet been loaded into the
          module this flag is `0` (not ready).
        '''
        tags: ["excl:CsrAllTests:CsrExclCheck"]
      }
      { bits: "4",
        name: "ALERT_FATAL_FAULT",
        resval: "0",
        desc:  '''
          No fatal fault has occurred inside the AES unit (0).
          A fatal fault has occurred and the AES unit needs to be reset (1).
          Examples for fatal faults include
          i) storage errors in the Control Register,
          ii) if any internal FSM enters an invalid state,
          iii) if any sparsely encoded signal takes on an invalid value,
          iv) errors in the internal round counter,
          v) escalations triggered by the life cycle controller, and
          vi) fatal integrity failures on the TL-UL bus.
        '''
      }
    ]
  }
  ]
}
